`include "pl_regs.vh" //automatically created and added by fwk with conf variables such a C_VERSION ...

/* default values of defined variables */
`ifndef C_ID
`define C_ID 0xE1C00100
`endif
`ifndef C_VERSION
`define C_VERSION 0x00000000
`endif
`ifndef C_PRJ_ID
`define C_PRJ_ID 0xE1C00010
`endif
`ifndef C_PRJ_VERSION
`define C_PRJ_VERSION 0x00000000
`endif
`ifndef C_PRJ_TIMESTAMP
`define C_PRJ_TIMESTAMP 0x00000000
`endif
`ifndef C_PRJ_SHASUM
`define C_PRJ_SHASUM 0x00000000
`endif

/*
  module a address space
*/
addrmap pl_regs {
  name = "Example module for the example application";
  desyrdl_interface = "AXI4L";

  reg {
    desc = "Module Identification Number";
    default sw = r;
    default hw = r;
    field {} data[32] = `C_ID;
  } ID @0x00;

  reg {
    desc = "Module Version Number";
    default sw = r;
    default hw = r;
    field {} changes [8] =  `C_VERSION & 0x000000FF;
    field {} patch [8]   = (`C_VERSION & 0x0000FF00) >> 8;
    field {} minor [8]   = (`C_VERSION & 0x00FF0000) >> 16;
    field {} major [8]   = (`C_VERSION & 0xFF000000) >> 24;
  } VERSION @0x04;

  reg {
    desc="Project Identification Number";
    default sw = r;
    default hw = r;
    field {} data[32] = `C_PRJ_ID;
  } PRJ_ID @0x10;

  reg {
    desc="Project Version Number";
    default sw = r;
    default hw = r;
    field {} changes [8] =  `C_PRJ_VERSION & 0x000000FF;
    field {} patch [8]   = (`C_PRJ_VERSION & 0x0000FF00) >> 8;
    field {} minor [8]   = (`C_PRJ_VERSION & 0x00FF0000) >> 16;
    field {} major [8]   = (`C_PRJ_VERSION & 0xFF000000) >> 24;
  } PRJ_VERSION @0x14;

  reg {
    desc="Project Repository check sum.";
    default sw = r;
    default hw = r;
      field {} data[32] = `C_PRJ_SHASUM;
  } PRJ_SHASUM @0x18;

  reg {
    desc="Project compilation timestamp";
    default sw = r;
    default hw = r;
    field {} data[32] = `C_PRJ_TIMESTAMP;
  } PRJ_TIMESTAMP @0x1C;

 
reg {
    desc="Freq Measure Clk0";
    default sw = r;
    default hw = w;  
    field {} val[32];
  } freq_clk0 @0x20; 
  
reg {
    desc="Freq Measure Clk1";
    default sw = r;
    default hw = w;  
    field {} val[32];
  } freq_clk1 @0x24;   
  
reg {
    desc="Freq Measure Clk2";
    default sw = r;
    default hw = w;  
    field {} val[32];
  } freq_clk2 @0x28; 
  
reg {
    desc="Freq Measure Clk3";
    default sw = r;
    default hw = w;  
    field {} val[32];
  } freq_clk3 @0x2C;    
  
reg {
    desc="Freq Measure Clk4";
    default sw = r;
    default hw = w;  
    field {} val[32];
  } freq_clk4 @0x30;  
  
  
  

   
 
 reg {
    desc="Trigger Source:  0=evr, 1=int";
    default sw = rw;
    default hw = r;
    field {} data[1];
  } clk_trigsrc @0xB8;
 
 
reg {
    desc="EVR Reset";
    default sw = rw;
    default hw = r;
    field {} data[1] = 0;
  } evr_reset @0xBC;
  
 

  

/*  DMA Registers */
reg {
    desc="DMA Soft Trigger";
    default sw = rw;
    default hw = r;
    field {} data[1];
  } dma_soft_trig @0x100;

reg {
    desc="DMA ADC Enable";
    default sw = rw;
    default hw = r;
    field {} data[1];
  } dma_adc_enb @0x108;

reg {
    desc="DMA ADC Length";
    default sw = rw;
    default hw = r;
    field {} data[32] = 100000;
  } dma_adc_len @0x10C;


reg {
    desc="DMA Test Data Enb";
    default sw = rw;
    default hw = r;
    field {} data[1];
  } dma_testdata_enb @0x120;
  
 reg {
    desc="DMA Trigger Source:  0=evr, 1=soft";
    default sw = rw;
    default hw = r;
    field {} data[1] = 1;
  } dma_trigsrc @0x124;
 
reg {
    desc="DMA Trig Count";
    default sw = r;
    default hw = w;
    field {} data[32];
  } dma_trigcnt @0x128;
   


 reg {
    desc="FP LED outputs";
    default sw = rw;
    default hw = r;
    field {} val[8];
  } FP_LEDS @0x140;







/* EVR Registers */
 reg {
    desc="Timestamp (ns)";
    default sw = r;
    default hw = w;
    field {} val[32];
  } ts_ns @0x150;

reg {
    desc="Timestamp (s)";
    default sw = r;
    default hw = w;
    field {} val[32];
  } ts_s @0x154;
  
reg {
    desc="DMA Trigger Timestamp (ns)";
    default sw = r;
    default hw = w;
    field {} val[32];
  } dma_ts_ns @0x158;

reg {
    desc="DMA Trigger Timestamp (s)";
    default sw = r;
    default hw = w;
    field {} val[32];
  } dma_ts_s @0x15C;  

reg {
    desc="DMA Trigger Event Number";
    default sw = rw;
    default hw = r;
    field {} val[8];
  } dma_trig_eventno @0x160;  

reg {
    desc="DMA Trigger Delay";
    default sw = rw;
    default hw = r;
    field {} val[32];
  } dma_trig_delay @0x164;  


 
/* rfSOC DAC Dual Port Memory write registers */


 reg {
    desc="DAC DPRAM Select";
    default sw = rw;
    default hw = r;
    field {} val[8];
  } rfdac_dpram_sel @0x200;

reg {
    desc="DAC DPRAM Number of Samples";
    default sw = rw;
    default hw = r;
    default swacc=true;
    default swmod=true;   
    field {} val[16];
  } rfdac_dpram_numpts @0x204;

 reg {
    desc="DAC DPRAM Sync to TBT";
    default sw = rw;
    default swacc=true;
    default swmod=true;   
    default hw = r;
    field {} val[1];
  } rfdac_dpram_sync2tbt @0x208;

reg {
    desc="DAC DPRAM Loop Enable";
    default sw = rw;
    default swacc=true;
    default swmod=true;   
    default hw = r;
    field {} val[1];
  } rfdac_dpram_loopenb @0x20C;

reg {
    desc="DAC DPRAM Trigger";
    default sw = rw;
    default swacc=true;
    default swmod=true;   
    default hw = r;
    field {} val[1];
  } rfdac_dpram_trig @0x210;


 reg {
    desc="DAC DPRAM Address";
    default sw = rw;
    default hw = r;
    field {} val[16];
  } rfdac_dpram_addr @0x220;

 reg {
    desc="DAC DPRAM Data";
    default sw = rw;
    default hw = r;
    field {} val[16];
  } rfdac_dpram_data @0x224;

 reg {
    desc="DAC DPRAM we";
    default sw = rw;
    default hw = r;
    default swacc=true;
    default swmod=true;
    field {} val[1];
  } rfdac_dpram_we @0x228;
 
 
 
 

/* RfSOC raw ADC FIFO registers */

  reg {
    desc="ADC FIFO Reset";
    default sw = rw;
    default hw = r;
    default swacc=true;
    default swmod=true;
    field {} data[1];
  } rfadcfifo_reset @0x400;

  reg {
    desc="ADC FIFO Trig";
    default sw = rw;
    default hw = r;
    default swacc=true;
    default swmod=true;
    field {} data[1];
  } rfadcfifo_trig @0x404;


  reg {
    desc="ADC0 FIFO Data";
    default sw = r;
    default hw = w;
    default swacc=true;
    default swmod=true;
    field {} data[32];
  } rfadc0fifo_dout @0x450;

   reg {
    desc="ADC0 FIFO Word Count";
    default sw = r;
    default hw = w;
    field {} data[32];
  } rfadc0fifo_wdcnt @0x454;

 reg {
    desc="ADC1 FIFO Data";
    default sw = r;
    default hw = w;
    default swacc=true;
    default swmod=true;
    field {} data[32];
  } rfadc1fifo_dout @0x460;

   reg {
    desc="ADC1 FIFO Word Count";
    default sw = r;
    default hw = w;
    field {} data[32];
  } rfadc1fifo_wdcnt @0x464;
  
 reg {
    desc="ADC2 FIFO Data";
    default sw = r;
    default hw = w;
    default swacc=true;
    default swmod=true;
    field {} data[32];
  } rfadc2fifo_dout @0x470;

   reg {
    desc="ADC2 FIFO Word Count";
    default sw = r;
    default hw = w;
    field {} data[32];
  } rfadc2fifo_wdcnt @0x474;

 reg {
    desc="ADC3 FIFO Data";
    default sw = r;
    default hw = w;
    default swacc=true;
    default swmod=true;
    field {} data[32];
  } rfadc3fifo_dout @0x480;

   reg {
    desc="ADC3 FIFO Word Count";
    default sw = r;
    default hw = w;
    field {} data[32];
  } rfadc3fifo_wdcnt @0x484;



reg {
    desc="ADC4 FIFO Data";
    default sw = r;
    default hw = w;
    default swacc=true;
    default swmod=true;
    field {} data[32];
  } rfadc4fifo_dout @0x490;

reg {
    desc="ADC4 FIFO Word Count";
    default sw = r;
    default hw = w;
    field {} data[32];
} rfadc4fifo_wdcnt @0x494;


 reg {
    desc="ADC5 FIFO Data";
    default sw = r;
    default hw = w;
    default swacc=true;
    default swmod=true;
    field {} data[32];
  } rfadc5fifo_dout @0x4A0;

reg {
    desc="ADC5 FIFO Word Count";
    default sw = r;
    default hw = w;
    field {} data[32];
  } rfadc5fifo_wdcnt @0x4A4;
  
 reg {
    desc="ADC6 FIFO Data";
    default sw = r;
    default hw = w;
    default swacc=true;
    default swmod=true;
    field {} data[32];
  } rfadc6fifo_dout @0x4B0;

   reg {
    desc="ADC6 FIFO Word Count";
    default sw = r;
    default hw = w;
    field {} data[32];
  } rfadc6fifo_wdcnt @0x4B4;

 reg {
    desc="ADC7 FIFO Data";
    default sw = r;
    default hw = w;
    default swacc=true;
    default swmod=true;
    field {} data[32];
  } rfadc7fifo_dout @0x4C0;

reg {
    desc="ADC7 FIFO Word Count";
    default sw = r;
    default hw = w;
    field {} data[32];
  } rfadc7fifo_wdcnt @0x4C4;






};
